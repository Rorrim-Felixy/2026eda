simulator lang=spectre
global 0

include "truth_model.scs"

parameters VGS=0 VDS=5 TEMP_C=27
simulatorOptions options temp=TEMP_C tnom=27 reltol=1e-4

// Ports provide the DC bias, small-signal excitation, and SP reference planes.
Pg (g 0) port r=50 num=1 dc=VGS type=pulse \
    val0=-3 val1=0 delay=1u rise=100n fall=100n width=5u period=20u \
    mag=1
Pd (d 0) port r=50 num=2 dc=VDS mag=0

Xdut (d g 0 0) asm_truth

dcVg dc param=VGS start=-5 stop=2 step=0.1
dcVd dc param=VDS start=0 stop=10 step=0.1
acCV ac start=1M stop=1.001M lin=2
spS sp start=1M stop=20G dec=10
tranPulse tran stop=50u step=10n
noiseOne noise start=1k stop=100M dec=10 oprobe=Pd

save Pg:p Pd:p
